simulator lang=spectre
global 0
include "/scratch/s550a945/proj/PDK/GPDK/gpdk180_v3.3/models/spectre/gpdk.scs" section=NN
include "<dev_mod>"
include "top_netlist.scs"

<input_source>

Vvd (VDD 0) vsource dc=1.8 type=dc
Vvs (VSS 0) vsource dc=0 type=dc
Vae (AE 0) vsource dc=1.8 type=dc

simulatorOptions options psfversion="1.4.0" reltol=1e-3 vabstol=1e-6 \
    iabstol=1e-12 temp=27 tnom=27 scalem=1.0 scale=1.0 gmin=1e-12 rforce=1 \
    maxnotes=5 maxwarns=5 digits=5 cols=80 pivrel=1e-3 \
    sensfile="../psf/sens.output" checklimitdest=psf
tran tran stop=15n errpreset=conservative write="spectre.ic" \
    writefinal="spectre.fc" annotate=status maxiters=5
finalTimeOP info what=oppoint where=rawfile
modelParameter info what=models where=rawfile
element info what=inst where=rawfile
outputParameter info what=output where=rawfile
designParamVals info what=parameters where=rawfile
primitives info what=primitives where=rawfile
subckts info what=subckts where=rawfile
saveOptions options save=all pwr=all currents=all
